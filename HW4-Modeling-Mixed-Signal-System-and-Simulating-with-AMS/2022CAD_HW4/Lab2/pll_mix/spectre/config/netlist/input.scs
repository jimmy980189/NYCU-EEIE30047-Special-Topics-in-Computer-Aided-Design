// Design: PLL/pll_mix
simulator lang=spectre
global 0

// PLL/pll_mix/schematic
// functional systemVerilog schematic veriloga vhdl vhdlams wreal
I0 (net13 net6 net10 net8) pfd vlogic_high=1.8 vlogic_low=0 vtrans_up=0.9 vtrans_dn=0.9 tdelay_up_cp_switch=2.386e-10 tdelay_dn_cp_switch=2.386e-10 tr_up=1e-12 tf_up=1e-12 tr_dn=1e-12 tf_dn=1e-12 tdelay_reset=9.356e-11
I1 (net10 net8 net15 0) cp iamp=1 vtrans=0.9 tdel=0 trise=1e-12 tfall=1e-12 mis=0.52 tstop=4.28e-09 ioff=0 accurate=1 ioff_begin=0.24
I2 (net15 vctrl) LF R=2400 C1=6e-11 C2=3e-12 Beta=20 Icp=3.2e-05
I3 (vctrl fout) vco amp=0.9 vco_gain=1.1402e+09 freq_min=2.9472e+08 freq_max=9.8797e+08 vtrans=0.9 Vdd=1.8 n_load=1 v_min=0.59227 v_max=1.2
I4 (fout net9) sin2pulse vlogic_high=1.8 vlogic_low=0 vtrans=0.9 delay_div=0 trise=4e-11 tfall=4e-11
I5 (net6 net9 net7) divider_d
I6 (net7) stimulus_D
simulatorOptions options temp=27
tran tran stop=6u
ahdl_include "/edahome/course/2022CAD/2022CAD021/NYCU-EEIE30047-Special-Topics-in-Computer-Aided-Design/HW4-Modeling-Mixed-Signal-System-and-Simulating-with-AMS/2022CAD_HW4/Lab2/PLL/pfd/veriloga/veriloga.va"
ahdl_include "/edahome/course/2022CAD/2022CAD021/NYCU-EEIE30047-Special-Topics-in-Computer-Aided-Design/HW4-Modeling-Mixed-Signal-System-and-Simulating-with-AMS/2022CAD_HW4/Lab2/PLL/cp/veriloga/veriloga.va"
ahdl_include "/edahome/course/2022CAD/2022CAD021/NYCU-EEIE30047-Special-Topics-in-Computer-Aided-Design/HW4-Modeling-Mixed-Signal-System-and-Simulating-with-AMS/2022CAD_HW4/Lab2/PLL/LF/veriloga/veriloga.va"
ahdl_include "/edahome/course/2022CAD/2022CAD021/NYCU-EEIE30047-Special-Topics-in-Computer-Aided-Design/HW4-Modeling-Mixed-Signal-System-and-Simulating-with-AMS/2022CAD_HW4/Lab2/PLL/vco/veriloga/veriloga.va"
ahdl_include "/edahome/course/2022CAD/2022CAD021/NYCU-EEIE30047-Special-Topics-in-Computer-Aided-Design/HW4-Modeling-Mixed-Signal-System-and-Simulating-with-AMS/2022CAD_HW4/Lab2/PLL/sin2pulse/veriloga/veriloga.va"
